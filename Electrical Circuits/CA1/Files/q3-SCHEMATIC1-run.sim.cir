** Profile: "SCHEMATIC1-run"  [ C:\Users\Shahab\Desktop\ec\CA1\q3-schematic1-run.sim ]

** Creating circuit file "q3-schematic1-run.sim.cir"
** WARNING: THIS AUTOMATICALLY GENERATED FILE MAY BE OVERWRITTEN BY SUBSEQUENT SIMULATIONS

*Libraries:
* Local Libraries :
* From [PSPICE NETLIST] section of C:\Program Files\Orcad\PSpice\PSpice.ini file:
.lib "nom.lib"

*Analysis directives:
.PROBE V(*) I(*) W(*) D(*) NOISE(*)
.INC ".\q3-SCHEMATIC1.net"

.END
