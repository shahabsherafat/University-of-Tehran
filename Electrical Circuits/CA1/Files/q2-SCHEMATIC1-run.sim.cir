** Profile: "SCHEMATIC1-run"  [ C:\Users\Shahab\Desktop\ec\CA1\q2-SCHEMATIC1-run.sim ]

** Creating circuit file "q2-SCHEMATIC1-run.sim.cir"
** WARNING: THIS AUTOMATICALLY GENERATED FILE MAY BE OVERWRITTEN BY SUBSEQUENT SIMULATIONS

*Libraries:
* Local Libraries :
* From [PSPICE NETLIST] section of C:\Program Files\Orcad\PSpice\PSpice.ini file:
.lib "nom.lib"

*Analysis directives:
.DC LIN I_I3 0 10 0.5
.PROBE V(*) I(*) W(*) D(*) NOISE(*)
.INC ".\q2-SCHEMATIC1.net"

.END
