** Profile: "SCHEMATIC1-hg"  [ C:\Users\Shahab\Desktop\ec\CA1\q3-SCHEMATIC1-hg.sim ]

** Creating circuit file "q3-SCHEMATIC1-hg.sim.cir"
** WARNING: THIS AUTOMATICALLY GENERATED FILE MAY BE OVERWRITTEN BY SUBSEQUENT SIMULATIONS

*Libraries:
* Local Libraries :
* From [PSPICE NETLIST] section of C:\Program Files\Orcad\PSpice\PSpice.ini file:
.lib "nom.lib"

*Analysis directives:
.TRAN  0 4000us 0
.PROBE V(*) I(*) W(*) D(*) NOISE(*)
.INC ".\q3-SCHEMATIC1.net"

.END
