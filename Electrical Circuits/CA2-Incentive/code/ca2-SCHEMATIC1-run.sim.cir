** Profile: "SCHEMATIC1-run"  [ C:\USERS\SHAHAB\DESKTOP\EC\CA2\ca2-SCHEMATIC1-run.sim ]

** Creating circuit file "ca2-SCHEMATIC1-run.sim.cir"
** WARNING: THIS AUTOMATICALLY GENERATED FILE MAY BE OVERWRITTEN BY SUBSEQUENT SIMULATIONS

*Libraries:
* Local Libraries :
* From [PSPICE NETLIST] section of C:\Program Files\Orcad\PSpice\PSpice.ini file:
.lib "nom.lib"

*Analysis directives:
.TRAN  0 5m 0
.PROBE V(*) I(*) W(*) D(*) NOISE(*)
.INC ".\ca2-SCHEMATIC1.net"

.END
